* ============================================================
* xmitter Rev C analog + SS PA chain, 14.2 MHz (20m)
*                           *** WITH 20m band LPF ***
*
* Same chain as revc_chain_20m.cir, but with a 7-pole Chebyshev
* 0.1 dB ripple LPF (Fc = 18 MHz) spliced between T1 secondary
* and the 50 ohm load. All harmonics must pass through this LPF
* to reach the antenna.
*
* LPF design (CLCLCLC, equal source/load Z=50):
*   g1..g7 (0.1dB, 7th order) = 1.1812, 1.4228, 2.0966, 1.5733,
*                               2.0966, 1.4228, 1.1812
*   with wc = 2*pi*18e6
*   C1 = g1/(wc*Z) = 209 pF
*   L2 = g2*Z/wc  = 629 nH
*   C3 = g3/(wc*Z) = 371 pF
*   L4 = g4*Z/wc  = 695 nH
*   C5 = C3,  L6 = L2,  C7 = C1
* ============================================================

.INCLUDE "40673.lib"

.SUBCKT LM7171B INP INN VP VN OUT
E_INT  N1 0  INP INN 1E6
R_P    N1 N2  1MEG
C_P    N2 0  1n
B_OUT  OUT 0  V = MAX(V(VN)+1, MIN(V(VP)-1, V(N2)))
.ENDS

.SUBCKT IRF510 D G S
MN DI GI SI SI MOSN L=100u W=100u
.MODEL MOSN NMOS LEVEL=1 VTO=3.57 KP=0.4 LAMBDA=0.0082 IS=1e-32
+  CGSO=5.07e-7 CGDO=2.74e-8
RD D DI 0.1
RG G GI 1
RS SI S 0.045
DBD S D DBODY
.MODEL DBODY D IS=1.08e-15 VJ=0.5 CJO=174p M=0.3
.ENDS

V_P12  VP12 0  DC 12
V_N12  VN12 0  DC -12
V_PA   VPA  0  DC 13.8

V_RF   Q2_G1 0  PULSE(-1.65 1.65 0 1n 1n 34.211n 70.422n)
V_G2   G2 0  DC 4

* ---------- DGFET + reconstruction LPF ----------
X_Q2   Q2_G1  G2  Q2_D  0  40673
R31    VP12   Q2_D  470
C10    Q2_D   LPF_IN 10n
R_LPFBIAS LPF_IN 0 50

C_L1   LPF_IN  0      100p
L_L2   LPF_IN  LPF_B  500n
C_L3   LPF_B   0      100p
R_LPFLOAD LPF_B 0  50

* ---------- LM7171 chain ----------
X_U10  LPF_B  U10_OUT  VP12  VN12  U10_OUT  LM7171B

X_U11  U10_OUT  U11_FB  VP12  VN12  OUT_P  LM7171B
R_U11F OUT_P    U11_FB  4k
R_U11G U11_FB   0       1k

X_U12  0         U12_IN  VP12  VN12  OUT_N  LM7171B
R_U12I U10_OUT   U12_IN  1k
R_U12F OUT_N     U12_IN  5k

* ---------- IRF510 PP gate drive ----------
V_BIAS G_BIAS 0  DC 4.0
R_GA   G_BIAS G_A  22
R_GB   G_BIAS G_B  22
C_GA   OUT_P  G_A  100n
C_GB   OUT_N  G_B  100n

X_M1   D_A  G_A  0  IRF510
X_M2   D_B  G_B  0  IRF510

* ---------- T2 drain feed, T1 output xfmr ----------
L_T2A  VPA  D_A  15u
L_T2B  VPA  D_B  15u
K_T2AB L_T2A  L_T2B  0.98
C_T2B  VPA  0  100n

L_T1A  D_A    PRI_CT 2.2u
L_T1B  PRI_CT D_B    2.2u
L_T1S  XFMR   0      19.8u
K_T1AS L_T1A  L_T1S  0.98
K_T1BS L_T1B  L_T1S  0.98
K_T1AB L_T1A  L_T1B  0.98
C_T1C  PRI_CT 0  100n

* ============================================================
*  20m band LPF -- 7-pole Chebyshev 0.1 dB, Fc = 18 MHz, Z=50
* ============================================================
C_B1   XFMR   0        209p
L_B2   XFMR   LPF_N1   629n
C_B3   LPF_N1 0        371p
L_B4   LPF_N1 LPF_N2   695n
C_B5   LPF_N2 0        371p
L_B6   LPF_N2 OUT      629n
C_B7   OUT    0        209p

R_LOAD OUT  0  50

* ============================================================
.OPTIONS RELTOL=1e-3 ABSTOL=1n VNTOL=1u ITL1=300 ITL4=200
.IC V(G_A) = 4
.IC V(G_B) = 4

.control
tran 500p 3u 0
write spice4qucs.tr1.plot v(xfmr) v(out) v(d_a) v(d_b) v(g_a) v(g_b) v(out_p) v(out_n)
linearize v(out)
fft v(out)
let out_fft = v(out)
write spice4qucs.fft.plot out_fft
destroy all
exit
.endc

.END
